// Design: tmdc_fet/sram_write
simulator lang=spectre
global 0 vdd!

// tmdc_fet/inverter/schematic
subckt inverter In Out
    I8 (Out In 0) TMDC_nFET
    I7 (Out In vdd!) TMDC_pFET
ends inverter

// tmdc_fet/sram_write/schematic
V0 (vdd! 0) vsource dc=500.0m type=dc
V1 (WL 0) vsource type=pulse val0=0 val1=0.5V period=1n delay=100.0p rise=100.0p fall=100.0p width=500.0p
C1 (NBL 0) capacitor c=100.0a
C0 (BL 0) capacitor c=100.0a
I3 (NBL WL NBL_internal) TMDC_nFET
I2 (BL WL BLinternal) TMDC_nFET
I9 (0 BL) inverter
I10 (vdd! NBL) inverter
I1 (NBL_internal BLinternal) inverter
I0 (BLinternal NBL_internal) inverter
ic NBL=0 BLinternal=0 NBL_internal=0.5 BL=0.5
simulatorOptions options temp=27
tran tran stop=1n
ahdl_include "nfet.va"
ahdl_include "pfet.va"
