// Design: tmdc_fet/sram
simulator lang=spectre
global 0 vdd!
parameters Vsup=0.5

// tmdc_fet/inverter/schematic
subckt inverter In Out
    I8 (Out In 0) TMDC_nFET
    I7 (Out In vdd!) TMDC_pFET
ends inverter

// tmdc_fet/sram/schematic
V1 (WL 0) vsource type=pulse val0=0 val1=0.5V period=1n delay=100.0p rise=100.0p fall=100.0p width=500.0p
V0 (vdd! 0) vsource dc=Vsup type=dc
C1 (NBL 0) capacitor c=100.0a
C0 (BL 0) capacitor c=100.0a
I3 (NBL WL NBL_internal) TMDC_nFET
I2 (BL WL BLinternal) TMDC_nFET
I1 (NBL_internal BLinternal) inverter
I0 (BLinternal NBL_internal) inverter
ic NBL_internal=0.5 NBL=0.5 BL=0.5 BLinternal=0
simulatorOptions options temp=27
tran tran stop=1n
ahdl_include "nfet.va"
ahdl_include "pfet.va"
