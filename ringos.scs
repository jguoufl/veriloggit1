// Design: nmos2/Ringos
simulator lang=spectre
global 0 vdd!
parameters Vsup=0.5

// nmos2/inverter/schematic
subckt inverter In Out
    I8 (Out In 0) TMDC_nFET
    I7 (Out In vdd!) TMDC_pFET
ends inverter

// nmos2/Ringos/schematic
V0 (vdd! 0) vsource dc=Vsup type=dc
I4 (net6 net11) inverter
I3 (V3 net6) inverter
I2 (V2 V3) inverter
I1 (V1 V2) inverter
I0 (net11 V1) inverter
ic net11=0
simulatorOptions options temp=27
tran tran stop=500p
ahdl_include "nfet.va"
ahdl_include "pfet.va"
