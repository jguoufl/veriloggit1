// Design: nmos2/nmos2_test
simulator lang=spectre
global 0
parameters Vg=0.5 Vd=0.5

// nmos2/nmos2_test/schematic
V1 (net7 0) vsource dc=Vd type=dc
V0 (net3 0) vsource dc=Vg type=dc
I0 (net7 net3 0) TMDC_nFET
simulatorOptions options temp=27
dc dc param=Vd start=0 stop=0.5
save I0:Drain
ahdl_include "nfet.va"
