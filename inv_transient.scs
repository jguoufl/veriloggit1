// Design: nmos2/test_inv1
simulator lang=spectre
global 0 vdd!
parameters Vsup=0.5

// nmos2/inverter/schematic
subckt inverter In Out
    I8 (Out In 0) TMDC_nFET
    I7 (Out In vdd!) TMDC_pFET
ends inverter

// nmos2/test_inv1/schematic
V1 (vdd! 0) vsource dc=Vsup type=dc
C0 (net7 0) capacitor c=10.00a
V0 (Vin 0) vsource type=pulse val0=0 val1=500.0m period=8p delay=1p rise=100.0f fall=100.0f width=4p
I10 (Vout net7) inverter
I9 (Vout net7) inverter
I8 (Vout net7) inverter
I4 (Vout net7) inverter
I0 (Vin Vout) inverter
simulatorOptions options temp=27
tran tran stop=10p
ahdl_include "nfet.va"
ahdl_include "pfet.va"
