// VerilogA for nFET

`include "constants.vams"
`include "disciplines.vams"

`define m0		9.1095e-31 		// free electron mass
`define pi		3.1416
`define hbar	1.05458e-34		//Modified planks constant
`define q		1.60218e-19		//Charge
`define epso	8.85418e-12		// Permittivity of free space
`define kBT		0.0259 			// eV
`define Egh		0.75		// in EV half of the bandgap

module TMDC_pFET(Drain, Gate, Source);

	inout Drain, Gate, Source;
	electrical Drain, Gate, Source; //External Nodes

	//Instance Parameters
	parameter integer para_cap=1 from [0:1];			// 0 for non-parasitic, 1 for parasitic
	parameter real Lg = 100.0e-9 from [0:inf);			// Gate length
	parameter real Wg = 100.0e-9 from [0:inf);			// Gate Width

	parameter real tt = 10e-9 from [0:inf);			//top insulator  thickness
	parameter real epsort = 20.0 from [0:inf); 			//top dielectric of insulator

	parameter real tb = 300e-9 from [0:inf);			//top insulator  thickness
	parameter real epsorb = 4.0 from [0:inf); 			//top dielectric of insulator

	//Physical parameters
	parameter real me = 0.45 from [0:inf);			//transport effective mass of silicon

	//Physical parameters
	parameter real VFB = 0.5 from [-1.0:inf);			//Flat band voltage

	// mobility
	parameter real mu = 0.1 from [0:inf);	   // mobility

	//parameter for fitting function
	parameter real a0 =11.0 from [0:100];   // parameter in smoothing function

	//---------- Variables ----------------
	// Current, transmission, reflection, kT length
	real I_DS;
	//    Cg, Csig
	real Ct, Cb, Cg, Csig, Cgs, Cgd;

	// E-k related
	real mt, Egh;
	real D0, C0;

	// Bias condition
	real v_vd;			// Vdrain voltage
	real v_vs;			// Vsource voltage
	real v_vg;			// Vgate voltage

	// Threshold
	real Ecth;

	//********** the integral function for current
	analog function real gvc;
		input Vc, C0, Cg;
		real Vc, C0, Cg, xi;
		begin

			if (Vc>`Egh) begin
				gvc=(1+C0/Cg)*C0*(0.5*Vc*Vc+Vc*`Egh);
			end
			else begin
				xi=-(Vc+`Egh)/`kBT;
				gvc=C0*pow(`kBT,2.0)*exp(xi);
			end
		end
	endfunction

	//********** End of the integral function for current
	analog begin

		// Assign bias conditions
		v_vd = V(Drain);
		v_vs = V(Source);
		v_vg = V(Gate);

		//Assign basic parameters
		Ecth=`Egh-`kBT;
		D0=Lg*Wg*me*`m0/(`pi*pow(`hbar,2.0));
		C0=pow(`q,2.0)*D0;
		Ct=Lg*Wg*`epso*epsort/tt;
		Cb=Lg*Wg*`epso*epsorb/tb;
		Cg=Ct+Cb;
		Csig=Cg+C0;

		if (para_cap==1) begin
			Cgs=0.7*Cg;
			Cgd=0.3*Cg;
		end
		else begin
			Cgs=0;
			Cgd=0;
		end

		begin : evaluate_I_DS

			real vgs, vds;
			real Vp, VcL, VcP, Vcs, Vcd;

			// compute the current
			vgs = v_vg-v_vs-VFB;
			vds = v_vd-v_vs;
			Vp=0;
			VcL=Ct*vgs/Cg-Vp;  // Laplace for source, Vb=0
			VcP=(Ct*(vgs-Vp)+Cb*(0-Vp)-C0*Ecth)/Csig; // Poisson
			Vcs=VcP*(1-1/a0*ln(1+exp(a0*(1-VcL/VcP))));

			Vp=vds;
			VcL=Ct*vgs/Cg-Vp;  // Laplace for drain, Vb=0
			VcP=(Ct*(vgs-Vp)+Cb*(0-Vp)-C0*Ecth)/Csig; // Poisson
			Vcd=VcP*(1-1/a0*ln(1+exp(a0*(1-VcL/VcP))));

			I_DS=-mu*(gvc(Vcs,C0,Cg)-gvc(Vcd,C0,Cg))/pow(Lg,2.0);

		end  // End : evaluate_I_DS

		// Placing components
		// Voltage Controlled current source
		I(Drain,Source) <+ I_DS;

		// Gate to Source/Drain/Sub capacitance
		I(Gate,Source) <+ ddt(Cgs*V(Gate,Source));
		I(Gate,Drain)  <+ ddt(Cgd*V(Gate,Drain));

	end // End: analog begin
endmodule
