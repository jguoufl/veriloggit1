// Design: nmos2/pmos2_test
simulator lang=spectre
global 0
parameters Vg=-0.5 Vd=-0.5

// nmos2/pmos2_test/schematic
I5 (net7 net3 0) TMDC_pFET
V1 (net7 0) vsource dc=Vd type=dc
V0 (net3 0) vsource dc=Vg type=dc
simulatorOptions options temp=27
dc dc param=Vd start=-0.5 stop=0
save I5:Drain
ahdl_include "pfet.va"
